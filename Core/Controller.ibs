| / 7\'7
| \ \   Xilinx Inc.
| / /
| \_\/.\   IBIS Models for Spartan-3A
[IBIS ver]   3.2
[File name]   Controller.ibs
[File Rev]   2.3
[Date]   Sun Apr 15 11:46:44 2018
[Source]   HSPICE simulations
[Notes]   IBIS models for Spartan-3A Platform
[Disclaimer]
|   The data in this model is derived from SPICE simulations using
|   modeling information extracted from the target process. While
|   a great deal of care has been taken to provide information
|   that is accurate, this model is considered preliminary as it
|   has not been verified by actual silicon measurement. Treat the
|   data in this model as preliminary until actual silicon
|   verification is performed.
|   To accurately model package parasitics, please follow the
|   instructions at:  http://www.xilinx.com/xlnx/
|   xil_ans_display.jsp?getPagePath=11754
|   LVDS and LVPECL drivers require the use of external
|   termination resistors to provide the correct voltage levels.
|   For more information, refer to the Spartan-3 documentation.
|   NOTE: This file is compliant with IBIS Version 3.2, but it
|   may not implement all approved 3.2 features.
|   NOTE:  Newer versions of the buffer models may be available.
|   Check the web (http://www.xilinx.com/support/sw_ibis.htm) for
|   the latest file revision.  However, please be aware that the
|   web files are not compatible for use with IBISWriter, and
|   must be manually annotated, should their use be preferred.
[Copyright]
| Copyright 2006, Xilinx Inc., All rights reserved
|   Component Spartan-3A
[Component]   Spartan-3A
[Manufacturer]   Xilinx Inc.
[Package]
| For Package Type fgg484
| variable   typ   min   max
R_pkg   281.81m   154.29m   364.30m
L_pkg   5.74nH   2.89nH   8.53nH
C_pkg   0.98pF   0.57pF   1.68pF
[Pin]  signal_name   model_name
C7   VGA_B<0>   LVCMOS33_F_8_TB_33
D7   VGA_B<1>   LVCMOS33_F_8_TB_33
B9   VGA_B<2>   LVCMOS33_F_8_TB_33
C9   VGA_B<3>   LVCMOS33_F_8_TB_33
C5   VGA_G<0>   LVCMOS33_F_8_TB_33
D5   VGA_G<1>   LVCMOS33_F_8_TB_33
C6   VGA_G<2>   LVCMOS33_F_8_TB_33
D6   VGA_G<3>   LVCMOS33_F_8_TB_33
A3   VGA_R<0>   LVCMOS33_F_8_TB_33
B3   VGA_R<1>   LVCMOS33_F_8_TB_33
B8   VGA_R<2>   LVCMOS33_F_8_TB_33
C8   VGA_R<3>   LVCMOS33_F_8_TB_33
V8   SW   LVCMOS33_S_12_TB_33
C11   VGA_HSYNC   LVCMOS33_F_8_TB_33
B11   VGA_VSYNC   LVCMOS33_F_8_TB_33
R20   LED<0>   LVCMOS33_S_8_LR_33
T19   LED<1>   LVCMOS33_S_8_LR_33
U20   LED<2>   LVCMOS33_S_8_LR_33
U19   LED<3>   LVCMOS33_S_8_LR_33
V19   LED<4>   LVCMOS33_S_8_LR_33
V20   LED<5>   LVCMOS33_S_8_LR_33
Y22   LED<6>   LVCMOS33_S_8_LR_33
W21   LED<7>   LVCMOS33_S_8_LR_33
T14   BTN_NORTH   LVCMOS33_S_12_TB_33
T15   BTN_SOUTH   LVCMOS33_S_12_TB_33
T16   BTN_EAST   LVCMOS33_S_12_TB_33
U15   BTN_WEST   LVCMOS33_S_12_TB_33
E12   CLK_50M   LVCMOS33_S_12_TB_33
F5   TDI   LVCMOS25_S_12_TB_25
D4   TMS   LVCMOS25_S_12_TB_25
C1   IO_L01P_3   NC
D2   IO_L01N_3   NC
B1   IO_L02P_3   NC
C2   IO_L02N_3   NC
D3   IO_L03P_3   NC
E4   IO_L03N_3   NC
H8   IP_L04P_3   NC
H7   IP_L04N_3/VREF_3   NC
G6   IO_L05P_3   NC
G5   IO_L05N_3   NC
D1   IO_L06P_3   NC
E1   IO_L06N_3   NC
F4   IO_L07P_3   NC
E3   IO_L07N_3   NC
J8   IP_3/VREF_3   NC
F3   IO_L08P_3   NC
G4   IO_L08N_3   NC
H5   IO_L09P_3   NC
H6   IO_L09N_3   NC
K6   IO_L10P_3   NC
J5   IO_L10N_3   NC
J7   IP_L11P_3   NC
K8   IP_L11N_3   NC
F2   IO_L12P_3   NC
F1   IO_L12N_3   NC
G3   IO_L13P_3   NC
G1   IO_L13N_3   NC
H4   IO_L14P_3   NC
H3   IO_L14N_3   NC
K7   IP_L15P_3   NC
L8   IP_L15N_3/VREF_3   NC
H2   IO_L16P_3   NC
H1   IO_L16N_3   NC
J3   IO_L17P_3   NC
J1   IO_L17N_3/VREF_3   NC
K5   IO_L18P_3   NC
K4   IO_L18N_3   NC
L7   IP_L19P_3   NC
M8   IP_L19N_3   NC
K3   IO_L20P_3   NC
K2   IO_L20N_3   NC
L5   LHCLK0   NC
L3   LHCLK1   NC
K1   LHCLK2   NC
L1   IRDY2/LHCLK3   NC
M7   IP_L23P_3   NC
M6   IP_L23N_3   NC
M1   LHCLK4   NC
M2   LHCLK5   NC
M3   TRDY2/LHCLK6   NC
M4   LHCLK7   NC
N1   IO_L26P_3/VREF_3   NC
N3   IO_L26N_3   NC
N8   IP_L27P_3   NC
N9   IP_L27N_3   NC
P1   IO_L28P_3   NC
P2   IO_L28N_3   NC
P3   IO_L29P_3   NC
P5   IO_L29N_3   NC
M5   IO_L30P_3   NC
N4   IO_L30N_3   NC
N6   IP_L31P_3   NC
N5   IP_L31N_3   NC
R1   IO_L32P_3   NC
R2   IO_L32N_3   NC
R3   IO_L33P_3   NC
R4   IO_L33N_3   NC
R5   IO_L34P_3   NC
T4   IO_L34N_3   NC
N7   IP_L35P_3   NC
P8   IP_L35N_3   NC
T1   IO_L36P_3/VREF_3   NC
T3   IO_L36N_3   NC
U1   IO_L37P_3   NC
U2   IO_L37N_3   NC
V1   IO_L38P_3   NC
V3   IO_L38N_3   NC
P7   IP_L39P_3   NC
R8   IP_L39N_3   NC
T5   IO_L40P_3   NC
U5   IO_L40N_3   NC
U3   IO_L41P_3   NC
U4   IO_L41N_3   NC
W1   IO_L42P_3   NC
W2   IO_L42N_3   NC
R6   IP_3/VREF_3   NC
V4   IO_L43P_3   NC
W3   IO_L43N_3   NC
Y1   IO_L44P_3   NC
Y2   IO_L44N_3   NC
AA1   IO_L45P_3   NC
AA2   IO_L45N_3   NC
R7   IP_L46P_3   NC
T6   IP_L46N_3/VREF_3   NC
V6   M1   LVCMOS25_S_12_TB_25
W5   M0   LVCMOS25_S_12_TB_25
T7   IP_2/VREF_2   NC
W4   M2   LVCMOS25_S_12_TB_25
Y4   CSO_B   LVCMOS25_S_12_TB_25
V7   2   NC
AB2   IO_L03P_2   NC
AA3   IO_L03N_2   NC
U8   2   NC
AB3   IO_L04P_2   NC
AA4   IO_L04N_2   NC
W6   IO_L05P_2   NC
Y5   IO_L05N_2   NC
AB4   IO_L06P_2   NC
AB5   IO_L06N_2   NC
W7   IO_L07P_2   NC
Y6   IO_L07N_2   NC
T9   2   NC
AA6   IO_L08P_2   NC
AB6   IO_L08N_2   NC
V9   RDWR_B   LVCMOS25_S_12_TB_25
W9   VS2   LVCMOS25_S_12_TB_25
R9   2   NC
Y7   IO_L10P_2   NC
AB7   IO_L10N_2   NC
W8   VS1   LVCMOS25_S_12_TB_25
Y8   VS0   LVCMOS25_S_12_TB_25
T10   IP_2/VREF_2   NC
AA8   IO_L12P_2   NC
AB8   IO_L12N_2   NC
V10   IO_L13P_2   NC
Y10   IO_L13N_2   NC
U10   2   NC
Y9   D7   LVCMOS25_S_12_TB_25
AB9   D6   LVCMOS25_S_12_TB_25
AA10   IO_L15P_2   NC
AB10   IO_L15N_2   NC
R10   2   NC
Y11   D5   LVCMOS25_S_12_TB_25
AB11   D4   LVCMOS25_S_12_TB_25
U11   GCLK12   NC
V11   GCLK13   NC
T11   IP_2/VREF_2   NC
W12   GCLK14   NC
Y12   GCLK15   NC
AA12   GCLK0   NC
AB12   GCLK1   NC
R11   2   NC
V12   GCLK2   NC
U12   GCLK3   NC
AB13   IO_L21P_2   NC
Y13   IO_L21N_2   NC
R12   IP_2/VREF_2   NC
AA14   IO_L22P_2   NC
AB14   MOSI/CSI_B   LVCMOS25_S_12_TB_25
W13   IO_L23P_2   NC
Y14   IO_L23N_2   NC
P12   2   NC
AB15   AWAKE   NC
AA15   DOUT   LVCMOS25_S_12_TB_25
W15   IO_L25P_2   NC
Y15   IO_L25N_2   NC
R13   IP_2/VREF_2   NC
V13   INIT_B   LVCMOS25_S_12_TB_25
U13   D3   LVCMOS25_S_12_TB_25
AB16   IO_L27P_2   NC
Y16   IO_L27N_2   NC
T13   2   NC
AA17   D2   LVCMOS25_S_12_TB_25
Y17   D1   LVCMOS25_S_12_TB_25
AB17   IO_L29P_2   NC
AB18   IO_L29N_2   NC
R14   IP_2/VREF_2   NC
V14   IO_L30P_2   NC
V15   IO_L30N_2   NC
W16   IO_L31P_2   NC
V16   IO_L31N_2   NC
AB19   IO_L32P_2   NC
AA19   IO_L32N_2   NC
W18   IO_L33P_2   NC
V17   IO_L33N_2   NC
Y18   IO_L34P_2   NC
W17   IO_L34N_2   NC
AB21   IO_L35P_2   NC
AA21   IO_L35N_2   NC
AB20   D0/DIN/MISO   LVCMOS25_S_12_TB_25
AA20   CCLK   LVCMOS25_S_12_TB_25
Y19   DONE   LVCMOS25_S_12_TB_25
U18   SUSPEND   LVCMOS25_S_12_TB_25
AA22   HDC   LVCMOS25_S_12_TB_25
Y21   LDC2   LVCMOS25_S_12_TB_25
W19   LDC1   LVCMOS25_S_12_TB_25
W20   LDC0   LVCMOS25_S_12_TB_25
T17   A0   LVCMOS25_S_12_TB_25
T18   A1   LVCMOS25_S_12_TB_25
R15   IP_L04P_1   NC
R16   IP_L04N_1/VREF_1   NC
W22   IO_L07P_1   NC
V22   IO_L07N_1   NC
P15   IP_L08P_1   NC
P16   IP_L08N_1   NC
U22   IO_L09P_1   NC
U21   IO_L09N_1   NC
T20   IO_L11P_1   NC
T22   IO_L11N_1   NC
R17   IP_L12P_1   NC
R18   IP_L12N_1/VREF_1   NC
R21   IO_L14P_1   NC
R22   IO_L14N_1   NC
P20   IO_L15P_1   NC
P22   IO_L15N_1/VREF_1   NC
N15   IP_L16P_1   NC
N16   IP_L16N_1/VREF_1   NC
R19   A2   LVCMOS25_S_12_TB_25
P18   A3   LVCMOS25_S_12_TB_25
N22   A4   LVCMOS25_S_12_TB_25
N21   A5   LVCMOS25_S_12_TB_25
N20   A6   LVCMOS25_S_12_TB_25
N19   A7   LVCMOS25_S_12_TB_25
N18   A8   LVCMOS25_S_12_TB_25
N17   A9   LVCMOS25_S_12_TB_25
M22   RHCLK0   NC
L22   RHCLK1   NC
L21   RHCLK2   NC
L20   TRDY1/RHCLK3   NC
M17   IP_L23P_1   NC
M16   IP_L23N_1   NC
M18   RHCLK4   NC
M20   RHCLK5   NC
K20   IRDY1/RHCLK6   NC
K19   RHCLK7   NC
K22   A10   LVCMOS25_S_12_TB_25
J22   A11   LVCMOS25_S_12_TB_25
M15   IP_L27P_1/VREF_1   NC
L16   IP_L27N_1   NC
L18   IO_L28P_1   NC
L19   IO_L28N_1   NC
J21   A12   LVCMOS25_S_12_TB_25
J20   A13   LVCMOS25_S_12_TB_25
H22   A14   LVCMOS25_S_12_TB_25
G22   A15   LVCMOS25_S_12_TB_25
L15   IP_L31P_1   NC
K16   IP_L31N_1   NC
K17   IO_L32P_1   NC
K18   IO_L32N_1   NC
H21   A16   LVCMOS25_S_12_TB_25
H20   A17   LVCMOS25_S_12_TB_25
F22   A18   LVCMOS25_S_12_TB_25
F21   A19   LVCMOS25_S_12_TB_25
K14   IP_L35P_1/VREF_1   NC
K15   IP_L35N_1   NC
G19   IO_L36P_1   NC
G20   IO_L36N_1   NC
J18   IO_L37P_1   NC
H19   IO_L37N_1   NC
E20   IO_L38P_1   NC
F20   IO_L38N_1   NC
H17   IP_L39P_1   NC
H18   IP_L39N_1   NC
F19   IO_L40P_1   NC
F18   IO_L40N_1   NC
E22   IO_L41P_1   NC
D22   IO_L41N_1   NC
D21   IO_L42P_1   NC
D20   IO_L42N_1   NC
J16   IP_L43P_1   NC
J15   IP_L43N_1/VREF_1   NC
C22   A20   LVCMOS25_S_12_TB_25
C21   A21   LVCMOS25_S_12_TB_25
B22   A22   LVCMOS25_S_12_TB_25
B21   A23   LVCMOS25_S_12_TB_25
G18   A24   LVCMOS25_S_12_TB_25
G17   A25   LVCMOS25_S_12_TB_25
H16   IP_L47P_1/VREF_1   NC
H15   IP_L47N_1   NC
E19   TDO   LVCMOS25_S_12_TB_25
A21   TCK   LVCMOS25_S_12_TB_25
E17   IO_L01P_0   NC
D18   IO_L01N_0   NC
F16   0   NC
D19   IO_L02P_0/VREF_0   NC
C19   IO_L02N_0   NC
E16   0   NC
B20   IO_L03P_0   NC
A20   IO_L03N_0   NC
G15   0   NC
E15   IO_L04P_0   NC
F15   IO_L04N_0   NC
C18   IO_L05P_0   NC
A18   IO_L05N_0   NC
G16   0   NC
B19   IO_L06P_0/VREF_0   NC
A19   IO_L06N_0   NC
D17   IO_L07P_0   NC
C17   IO_L07N_0   NC
G14   0   NC
D16   IO_L08P_0   NC
C16   IO_L08N_0   NC
C14   IO_L09P_0   NC
E14   IO_L09N_0   NC
H14   0   NC
B17   IO_L10P_0   NC
A17   IO_L10N_0   NC
D15   IO_L11P_0   NC
C15   IO_L11N_0   NC
H13   0   NC
A16   IO_L12P_0   NC
A15   IO_L12N_0/VREF_0   NC
B15   IO_L13P_0   NC
A14   IO_L13N_0   NC
G13   0   NC
F13   IO_L14P_0   NC
E13   IO_L14N_0   NC
D13   IO_L15P_0   NC
C13   IO_L15N_0   NC
F12   0   NC
B13   IO_L16P_0   NC
A13   IO_L16N_0   NC
C12   GCLK4   NC
H12   IP_0/VREF_0   NC
A12   GCLK6   NC
A11   GCLK7   NC
G12   0   NC
D11   GCLK10   NC
E11   GCLK11   NC
A10   IO_L21P_0   NC
C10   IO_L21N_0   NC
G11   0   NC
A9   IO_L22P_0   NC
A8   IO_L22N_0   NC
D10   IO_L23P_0   NC
E10   IO_L23N_0   NC
H10   0   NC
G10   0   NC
A7   IO_L26P_0   NC
A6   IO_L26N_0   NC
F10   0   NC
B6   IO_L28P_0   NC
A5   IO_L28N_0   NC
H9   IP_0/VREF_0   NC
E9   IO_L30P_0   NC
D8   IO_L30N_0   NC
A4   IO_L31P_0   NC
B4   IO_L31N_0   NC
E8   0   NC
G9   0   NC
E7   IO_L34P_0   NC
F8   IO_L34N_0   NC
G8   IP_0/VREF_0   NC
F7   IO_L35P_0   NC
E6   IO_L35N_0   NC
G7   0   NC
B2   IO_L36P_0/VREF_0   NC
A2   PUDC_B   LVCMOS25_S_12_TB_25
C4   PROG_B   LVCMOS25_S_12_TB_25
A1   GND   GND
A22   GND   GND
AA11   GND   GND
AA16   GND   GND
AA7   GND   GND
AB1   GND   GND
AB22   GND   GND
B12   GND   GND
B16   GND   GND
B7   GND   GND
C20   GND   GND
C3   GND   GND
D14   GND   GND
D9   GND   GND
F11   GND   GND
F17   GND   GND
F6   GND   GND
G2   GND   GND
G21   GND   GND
J11   GND   GND
J13   GND   GND
J14   GND   GND
J19   GND   GND
J4   GND   GND
J9   GND   GND
K10   GND   GND
K12   GND   GND
L11   GND   GND
L13   GND   GND
L17   GND   GND
L2   GND   GND
L6   GND   GND
L9   GND   GND
M10   GND   GND
M12   GND   GND
M14   GND   GND
M21   GND   GND
N11   GND   GND
N13   GND   GND
P10   GND   GND
P14   GND   GND
P19   GND   GND
P4   GND   GND
P9   GND   GND
T12   GND   GND
T2   GND   GND
T21   GND   GND
U17   GND   GND
U6   GND   GND
W10   GND   GND
W14   GND   GND
Y20   GND   GND
Y3   GND   GND
D12   VCCAUX   POWER
E18   VCCAUX   POWER
E5   VCCAUX   POWER
H11   VCCAUX   POWER
L4   VCCAUX   POWER
M19   VCCAUX   POWER
P11   VCCAUX   POWER
V18   VCCAUX   POWER
V5   VCCAUX   POWER
W11   VCCAUX   POWER
J10   VCCINT   POWER
J12   VCCINT   POWER
K11   VCCINT   POWER
K13   VCCINT   POWER
K9   VCCINT   POWER
L10   VCCINT   POWER
L12   VCCINT   POWER
L14   VCCINT   POWER
M11   VCCINT   POWER
M13   VCCINT   POWER
M9   VCCINT   POWER
N10   VCCINT   POWER
N12   VCCINT   POWER
N14   VCCINT   POWER
P13   VCCINT   POWER
B10   VCCO_0   POWER
B14   VCCO_0   POWER
B18   VCCO_0   POWER
B5   VCCO_0   POWER
F14   VCCO_0   POWER
F9   VCCO_0   POWER
E21   VCCO_1   POWER
J17   VCCO_1   POWER
K21   VCCO_1   POWER
P17   VCCO_1   POWER
P21   VCCO_1   POWER
V21   VCCO_1   POWER
AA13   VCCO_2   POWER
AA18   VCCO_2   POWER
AA5   VCCO_2   POWER
AA9   VCCO_2   POWER
U14   VCCO_2   POWER
U9   VCCO_2   POWER
E2   VCCO_3   POWER
J2   VCCO_3   POWER
J6   VCCO_3   POWER
N2   VCCO_3   POWER
P6   VCCO_3   POWER
V2   VCCO_3   POWER
| Models and submodels in the file (4): LVCMOS25_S_12_TB_25 (I/O), LVCMOS33_F_8_TB_33 (I/O), LVCMOS33_S_12_TB_33 (I/O), LVCMOS33_S_8_LR_33 (I/O)
